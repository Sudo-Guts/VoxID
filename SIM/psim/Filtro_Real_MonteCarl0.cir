* Netlist C:\Users\Nesti\Documents\GUS\VoxID\SIM\psim\Filtro_Real.psimsch *

.include "C:\Altair\Altair_PSIM_2025\SPICElib\PSIM_SPICE.sub"

.ac dec 50 1 100k
.step param run 1 100 1

.include "C:\Users\Nesti\Documents\GUS\VoxID\SIM\spice\TL072.lib"

* HPF - Primera etapa
C_C1 1 2 {mc(470n,0.05)}
C_C2 2 3 {mc(470n,0.05)}
R_R1 2 4 {mc(1.30k,0.01)}
R_R2 3 0 {mc(8.87k,0.01)}

* HPF - Segunda etapa
C_C3 4 5 {mc(470n,0.05)}
C_C4 5 6 {mc(470n,0.05)}
R_R3 5 7 {mc(3.09k,0.01)}
R_R4 6 0 {mc(3.65k,0.01)}

* LPF - Primera etapa
C_C5 8 0 {mc(2.7n,0.05)}
C_C6 9 10 {mc(27n,0.05)}
R_R5 7 9 {mc(1.65k,0.01)}
R_R6 9 8 {mc(5.90k,0.01)}

* LPF - Segunda etapa
C_C7 11 0 {mc(20n,0.05)}
C_C8 12 13 {mc(27n,0.05)}
R_R7 10 12 {mc(787,0.01)}
R_R8 12 11 {mc(1.65k,0.01)}

V_Vsweep 1 0 ac 1
.param ACXin = 1

XU1 3 4 14 15 4 TL072
V_VDC1 0 15 DC 12
V_VDC2 14 0 DC 12
XU2 6 7 14 15 7 TL072
XU3 8 10 14 15 10 TL072
XU4 11 13 14 15 13 TL072
.save V(13)

* Matching PSIM probes to SPICE probes *
* V(V1) 	V(13) *

* Mediciones Monte Carlo
.meas AC GMAX MAX mag(V(13))
.meas AC FL WHEN mag(V(13))=GMAX/sqrt(2) RISE=1
.meas AC FH WHEN mag(V(13))=GMAX/sqrt(2) FALL=LAST
.meas AC BW PARAM FH-FL

.end
