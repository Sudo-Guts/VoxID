* Netlist C:\Users\Nesti\Downloads\Filtro_TL072.psimsch *

.include "C:\Altair\Altair_PSIM_2025\SPICElib\PSIM_SPICE.sub"

.tran 1.0e-006 1.0e-003 0  uic
* TL072 OPERATIONAL AMPLIFIER "MACROMODEL" SUBCIRCUIT
* CREATED USING PARTS RELEASE 4.01 ON 06/16/89 AT 13:08
* (REV N/A)      SUPPLY VOLTAGE: +/-15V
* CONNECTIONS:   NON-INVERTING INPUT
*                | INVERTING INPUT
*                | | POSITIVE POWER SUPPLY
*                | | | NEGATIVE POWER SUPPLY
*                | | | | OUTPUT
*                | | | | |
.SUBCKT TL072    1 2 3 4 5
*
  C1   11 12 3.498E-12
  C2    6  7 15.00E-12
  DC    5 53 DX
  DE   54  5 DX
  DLP  90 91 DX
  DLN  92 90 DX
  DP    4  3 DX
  EGND 99  0 POLY(2) (3,0) (4,0) 0 .5 .5
  FB    7 99 POLY(5) VB VC VE VLP VLN 0 4.715E6 -5E6 5E6 5E6 -5E6
  GA    6  0 11 12 282.8E-6
  GCM   0  6 10 99 8.942E-9
  ISS   3 10 DC 195.0E-6
  HLIM 90  0 VLIM 1K
  J1   11  2 10 JX
  J2   12  1 10 JX
  R2    6  9 100.0E3
  RD1   4 11 3.536E3
  RD2   4 12 3.536E3
  RO1   8  5 150
  RO2   7 99 150
  RP    3  4 2.143E3
  RSS  10 99 1.026E6
  VB    9  0 DC 0
  VC    3 53 DC 2.200
  VE   54  4 DC 2.200
  VLIM  7  8 DC 0
  VLP  91  0 DC 25
  VLN   0 92 DC 25
.MODEL DX D(IS=800.0E-18)
.MODEL JX PJF(IS=15.00E-12 BETA=270.1E-6 VTO=-1)
.ends
C_C1 3 4 1.6E-07 IC= 0
C_C2 4 1 1.6E-07 IC= 0
R_R1 4 2 3810
R_R2 1 0 26000
C_C3 2 7 1.6E-07 IC= 0
C_C4 7 5 1.6E-07 IC= 0
R_R3 7 6 9200
R_R4 5 0 10800
C_C5 8 0 2.7E-09 IC= 0
C_C6 10 9 2.7E-08 IC= 0
R_R5 6 10 1640
R_R6 10 8 5870
C_C7 11 0 2E-08 IC= 0
C_C8 13 12 2.7E-08 IC= 0
R_R7 9 13 779
R_R8 13 11 1670
V_Vsweep 3 0 SINE( 0 1  0 0 0 )

BACout_Vo1 ACXout_Vo1 0 V=V(12)/ACxin

XTL071 1 2 14 15 2 TL072
XTL072 5 6 14 15 6 TL072
XTL073 8 9 14 15 9 TL072
XTL74 11 12 14 15 12 TL072
V_VDC1 14 0 DC 12
V_VDC2 0 15 DC 12
.save V(12)
.save V(ACXout_Vo1)

* Matching PSIM probes to SPICE probes *
* V(V1) 	V(12) *
* V(Vo1) 	V(ACXout_Vo1) *

.end
